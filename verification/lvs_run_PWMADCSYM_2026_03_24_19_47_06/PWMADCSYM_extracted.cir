* Extracted by KLayout with SG13G2 LVS runset on : 24/03/2026 19:47

.SUBCKT PWMADCSYM
M$1 \$4 \$4 \$7 \$7 sg13_lv_nmos L=0.56u W=0.42u AS=0.1428p AD=0.1428p PS=1.52u
+ PD=1.52u rfmode=0
M$2 \$7 \$4 \$13 \$7 sg13_lv_nmos L=0.56u W=0.42u AS=0.1428p AD=0.1428p
+ PS=1.52u PD=1.52u rfmode=0
M$3 \$7 \$14 \$19 \$7 sg13_lv_nmos L=0.15u W=0.5u AS=0.17p AD=0.17p PS=1.68u
+ PD=1.68u rfmode=0
M$4 \$7 \$13 \$37 \$7 sg13_lv_nmos L=0.56u W=0.42u AS=0.1428p AD=0.1428p
+ PS=1.52u PD=1.52u rfmode=0
M$5 \$7 \$81 \$38 \$7 sg13_lv_nmos L=0.13u W=0.74u AS=0.2516p AD=0.1406p
+ PS=2.16u PD=1.12u rfmode=0
M$6 \$38 \$29 \$39 \$7 sg13_lv_nmos L=0.13u W=0.74u AS=0.1406p AD=0.1406p
+ PS=1.12u PD=1.12u rfmode=0
M$7 \$39 \$35 \$40 \$7 sg13_lv_nmos L=0.13u W=0.74u AS=0.1406p AD=0.1406p
+ PS=1.12u PD=1.12u rfmode=0
M$8 \$40 \$80 \$7 \$7 sg13_lv_nmos L=0.13u W=0.74u AS=0.1406p AD=0.2516p
+ PS=1.12u PD=2.16u rfmode=0
M$9 \$7 \$39 \$80 \$7 sg13_lv_nmos L=0.13u W=0.74u AS=0.2516p AD=0.1406p
+ PS=2.16u PD=1.12u rfmode=0
M$10 \$80 \$35 \$41 \$7 sg13_lv_nmos L=0.13u W=0.74u AS=0.1406p AD=0.1406p
+ PS=1.12u PD=1.12u rfmode=0
M$11 \$41 \$29 \$42 \$7 sg13_lv_nmos L=0.13u W=0.74u AS=0.1406p AD=0.1406p
+ PS=1.12u PD=1.12u rfmode=0
M$12 \$42 \$81 \$7 \$7 sg13_lv_nmos L=0.13u W=0.74u AS=0.1406p AD=0.2516p
+ PS=1.12u PD=2.16u rfmode=0
M$13 \$7 \$41 \$81 \$7 sg13_lv_nmos L=0.13u W=0.74u AS=0.2516p AD=0.2516p
+ PS=2.16u PD=2.16u rfmode=0
M$14 \$7 \$81 \$43 \$7 sg13_lv_nmos L=0.13u W=0.74u AS=0.2516p AD=0.2516p
+ PS=2.16u PD=2.16u rfmode=0
M$15 \$7 \$35 \$29 \$7 sg13_lv_nmos L=0.13u W=0.74u AS=0.2516p AD=0.2516p
+ PS=2.16u PD=2.16u rfmode=0
M$16 \$7 \$83 \$44 \$7 sg13_lv_nmos L=0.13u W=0.74u AS=0.2516p AD=0.1406p
+ PS=2.16u PD=1.12u rfmode=0
M$17 \$44 \$30 \$45 \$7 sg13_lv_nmos L=0.13u W=0.74u AS=0.1406p AD=0.1406p
+ PS=1.12u PD=1.12u rfmode=0
M$18 \$45 \$43 \$46 \$7 sg13_lv_nmos L=0.13u W=0.74u AS=0.1406p AD=0.1406p
+ PS=1.12u PD=1.12u rfmode=0
M$19 \$46 \$82 \$7 \$7 sg13_lv_nmos L=0.13u W=0.74u AS=0.1406p AD=0.2516p
+ PS=1.12u PD=2.16u rfmode=0
M$20 \$7 \$45 \$82 \$7 sg13_lv_nmos L=0.13u W=0.74u AS=0.2516p AD=0.1406p
+ PS=2.16u PD=1.12u rfmode=0
M$21 \$82 \$43 \$47 \$7 sg13_lv_nmos L=0.13u W=0.74u AS=0.1406p AD=0.1406p
+ PS=1.12u PD=1.12u rfmode=0
M$22 \$47 \$30 \$48 \$7 sg13_lv_nmos L=0.13u W=0.74u AS=0.1406p AD=0.1406p
+ PS=1.12u PD=1.12u rfmode=0
M$23 \$48 \$83 \$7 \$7 sg13_lv_nmos L=0.13u W=0.74u AS=0.1406p AD=0.2516p
+ PS=1.12u PD=2.16u rfmode=0
M$24 \$7 \$47 \$83 \$7 sg13_lv_nmos L=0.13u W=0.74u AS=0.2516p AD=0.2516p
+ PS=2.16u PD=2.16u rfmode=0
M$25 \$7 \$83 \$49 \$7 sg13_lv_nmos L=0.13u W=0.74u AS=0.2516p AD=0.2516p
+ PS=2.16u PD=2.16u rfmode=0
M$26 \$7 \$43 \$30 \$7 sg13_lv_nmos L=0.13u W=0.74u AS=0.2516p AD=0.2516p
+ PS=2.16u PD=2.16u rfmode=0
M$27 \$7 \$101 \$159 \$7 sg13_lv_nmos L=0.56u W=0.42u AS=0.1428p AD=0.1428p
+ PS=1.52u PD=1.52u rfmode=0
M$28 \$7 \$14 \$143 \$7 sg13_lv_nmos L=0.15u W=0.5u AS=0.17p AD=0.17p PS=1.68u
+ PD=1.68u rfmode=0
M$29 \$7 \$98 \$101 \$7 sg13_lv_nmos L=0.56u W=0.42u AS=0.1428p AD=0.1428p
+ PS=1.52u PD=1.52u rfmode=0
M$30 \$98 \$98 \$7 \$7 sg13_lv_nmos L=0.56u W=0.42u AS=0.1428p AD=0.1428p
+ PS=1.52u PD=1.52u rfmode=0
M$31 \$7 \$476 \$154 \$7 sg13_lv_nmos L=0.13u W=0.74u AS=0.2516p AD=0.2516p
+ PS=2.16u PD=2.16u rfmode=0
M$32 \$7 \$413 \$165 \$7 sg13_lv_nmos L=0.13u W=0.74u AS=0.2516p AD=0.2516p
+ PS=2.16u PD=2.16u rfmode=0
M$33 \$7 \$165 \$166 \$7 sg13_lv_nmos L=0.13u W=0.74u AS=0.2516p AD=0.1406p
+ PS=2.16u PD=1.12u rfmode=0
M$34 \$166 \$159 \$167 \$7 sg13_lv_nmos L=0.13u W=0.74u AS=0.1406p AD=0.2516p
+ PS=1.12u PD=2.16u rfmode=0
M$35 \$7 \$167 \$168 \$7 sg13_lv_nmos L=0.13u W=0.74u AS=0.2516p AD=0.1406p
+ PS=2.16u PD=1.12u rfmode=0
M$36 \$168 \$154 \$160 \$7 sg13_lv_nmos L=0.13u W=0.74u AS=0.1406p AD=0.2516p
+ PS=1.12u PD=2.16u rfmode=0
M$37 \$7 \$85 \$50 \$7 sg13_lv_nmos L=0.13u W=0.74u AS=0.2516p AD=0.1406p
+ PS=2.16u PD=1.12u rfmode=0
M$38 \$50 \$31 \$51 \$7 sg13_lv_nmos L=0.13u W=0.74u AS=0.1406p AD=0.1406p
+ PS=1.12u PD=1.12u rfmode=0
M$39 \$51 \$49 \$52 \$7 sg13_lv_nmos L=0.13u W=0.74u AS=0.1406p AD=0.1406p
+ PS=1.12u PD=1.12u rfmode=0
M$40 \$52 \$84 \$7 \$7 sg13_lv_nmos L=0.13u W=0.74u AS=0.1406p AD=0.2516p
+ PS=1.12u PD=2.16u rfmode=0
M$41 \$7 \$51 \$84 \$7 sg13_lv_nmos L=0.13u W=0.74u AS=0.2516p AD=0.1406p
+ PS=2.16u PD=1.12u rfmode=0
M$42 \$84 \$49 \$53 \$7 sg13_lv_nmos L=0.13u W=0.74u AS=0.1406p AD=0.1406p
+ PS=1.12u PD=1.12u rfmode=0
M$43 \$53 \$31 \$54 \$7 sg13_lv_nmos L=0.13u W=0.74u AS=0.1406p AD=0.1406p
+ PS=1.12u PD=1.12u rfmode=0
M$44 \$54 \$85 \$7 \$7 sg13_lv_nmos L=0.13u W=0.74u AS=0.1406p AD=0.2516p
+ PS=1.12u PD=2.16u rfmode=0
M$45 \$7 \$53 \$85 \$7 sg13_lv_nmos L=0.13u W=0.74u AS=0.2516p AD=0.2516p
+ PS=2.16u PD=2.16u rfmode=0
M$46 \$7 \$85 \$55 \$7 sg13_lv_nmos L=0.13u W=0.74u AS=0.2516p AD=0.2516p
+ PS=2.16u PD=2.16u rfmode=0
M$47 \$7 \$49 \$31 \$7 sg13_lv_nmos L=0.13u W=0.74u AS=0.2516p AD=0.2516p
+ PS=2.16u PD=2.16u rfmode=0
M$48 \$7 \$49 \$175 \$7 sg13_lv_nmos L=0.13u W=0.74u AS=0.2516p AD=0.1406p
+ PS=2.16u PD=1.12u rfmode=0
M$49 \$175 \$160 \$176 \$7 sg13_lv_nmos L=0.13u W=0.74u AS=0.1406p AD=0.2516p
+ PS=1.12u PD=2.16u rfmode=0
M$50 \$7 \$176 \$177 \$7 sg13_lv_nmos L=0.13u W=0.74u AS=0.2516p AD=0.1406p
+ PS=2.16u PD=1.12u rfmode=0
M$51 \$177 \$160 \$178 \$7 sg13_lv_nmos L=0.13u W=0.74u AS=0.1406p AD=0.2516p
+ PS=1.12u PD=2.16u rfmode=0
M$52 \$7 \$176 \$179 \$7 sg13_lv_nmos L=0.13u W=0.74u AS=0.2516p AD=0.1406p
+ PS=2.16u PD=1.12u rfmode=0
M$53 \$179 \$49 \$180 \$7 sg13_lv_nmos L=0.13u W=0.74u AS=0.1406p AD=0.2516p
+ PS=1.12u PD=2.16u rfmode=0
M$54 \$7 \$180 \$181 \$7 sg13_lv_nmos L=0.13u W=0.74u AS=0.2516p AD=0.1406p
+ PS=2.16u PD=1.12u rfmode=0
M$55 \$181 \$178 \$182 \$7 sg13_lv_nmos L=0.13u W=0.74u AS=0.1406p AD=0.2516p
+ PS=1.12u PD=2.16u rfmode=0
M$56 \$7 \$182 \$183 \$7 sg13_lv_nmos L=0.13u W=0.74u AS=0.2516p AD=0.2516p
+ PS=2.16u PD=2.16u rfmode=0
M$57 \$7 \$211 \$184 \$7 sg13_lv_nmos L=0.13u W=0.74u AS=0.2516p AD=0.2516p
+ PS=2.16u PD=2.16u rfmode=0
M$58 \$7 \$184 \$185 \$7 sg13_lv_nmos L=0.13u W=0.74u AS=0.2516p AD=0.1406p
+ PS=2.16u PD=1.12u rfmode=0
M$59 \$185 \$43 \$186 \$7 sg13_lv_nmos L=0.13u W=0.74u AS=0.1406p AD=0.2516p
+ PS=1.12u PD=2.16u rfmode=0
M$60 \$7 \$186 \$161 \$7 sg13_lv_nmos L=0.13u W=0.74u AS=0.2516p AD=0.2516p
+ PS=2.16u PD=2.16u rfmode=0
M$61 \$7 \$183 \$187 \$7 sg13_lv_nmos L=0.13u W=0.74u AS=0.2516p AD=0.1406p
+ PS=2.16u PD=1.12u rfmode=0
M$62 \$187 \$161 \$188 \$7 sg13_lv_nmos L=0.13u W=0.74u AS=0.1406p AD=0.2516p
+ PS=1.12u PD=2.16u rfmode=0
M$63 \$7 \$188 \$189 \$7 sg13_lv_nmos L=0.13u W=0.74u AS=0.2516p AD=0.2516p
+ PS=2.16u PD=2.16u rfmode=0
M$64 \$7 \$189 \$190 \$7 sg13_lv_nmos L=0.13u W=0.74u AS=0.2516p AD=0.1406p
+ PS=2.16u PD=1.12u rfmode=0
M$65 \$190 \$162 \$191 \$7 sg13_lv_nmos L=0.13u W=0.74u AS=0.1406p AD=0.2516p
+ PS=1.12u PD=2.16u rfmode=0
M$66 \$212 \$212 \$7 \$7 sg13_lv_nmos L=0.56u W=0.42u AS=0.1428p AD=0.1428p
+ PS=1.52u PD=1.52u rfmode=0
M$67 \$7 \$212 \$244 \$7 sg13_lv_nmos L=0.56u W=0.42u AS=0.1428p AD=0.1428p
+ PS=1.52u PD=1.52u rfmode=0
M$68 \$7 \$14 \$251 \$7 sg13_lv_nmos L=0.15u W=0.5u AS=0.17p AD=0.17p PS=1.68u
+ PD=1.68u rfmode=0
M$69 \$7 \$244 \$325 \$7 sg13_lv_nmos L=0.56u W=0.42u AS=0.1428p AD=0.1428p
+ PS=1.52u PD=1.52u rfmode=0
M$70 \$7 \$413 \$259 \$7 sg13_lv_nmos L=0.13u W=0.74u AS=0.2516p AD=0.2516p
+ PS=2.16u PD=2.16u rfmode=0
M$71 \$7 \$259 \$260 \$7 sg13_lv_nmos L=0.13u W=0.74u AS=0.2516p AD=0.1406p
+ PS=2.16u PD=1.12u rfmode=0
M$72 \$260 \$325 \$252 \$7 sg13_lv_nmos L=0.13u W=0.74u AS=0.1406p AD=0.2516p
+ PS=1.12u PD=2.16u rfmode=0
M$73 \$7 \$476 \$261 \$7 sg13_lv_nmos L=0.13u W=0.74u AS=0.2516p AD=0.2516p
+ PS=2.16u PD=2.16u rfmode=0
M$74 \$7 \$261 \$262 \$7 sg13_lv_nmos L=0.13u W=0.74u AS=0.2516p AD=0.1406p
+ PS=2.16u PD=1.12u rfmode=0
M$75 \$262 \$448 \$263 \$7 sg13_lv_nmos L=0.13u W=0.74u AS=0.1406p AD=0.2516p
+ PS=1.12u PD=2.16u rfmode=0
M$76 \$7 \$263 \$264 \$7 sg13_lv_nmos L=0.13u W=0.74u AS=0.2516p AD=0.1406p
+ PS=2.16u PD=1.12u rfmode=0
M$77 \$264 \$252 \$265 \$7 sg13_lv_nmos L=0.13u W=0.74u AS=0.1406p AD=0.2516p
+ PS=1.12u PD=2.16u rfmode=0
M$78 \$7 \$55 \$280 \$7 sg13_lv_nmos L=0.13u W=0.74u AS=0.2516p AD=0.1406p
+ PS=2.16u PD=1.12u rfmode=0
M$79 \$280 \$266 \$281 \$7 sg13_lv_nmos L=0.13u W=0.74u AS=0.1406p AD=0.2516p
+ PS=1.12u PD=2.16u rfmode=0
M$80 \$7 \$281 \$282 \$7 sg13_lv_nmos L=0.13u W=0.74u AS=0.2516p AD=0.1406p
+ PS=2.16u PD=1.12u rfmode=0
M$81 \$282 \$266 \$267 \$7 sg13_lv_nmos L=0.13u W=0.74u AS=0.1406p AD=0.2516p
+ PS=1.12u PD=2.16u rfmode=0
M$82 \$7 \$281 \$283 \$7 sg13_lv_nmos L=0.13u W=0.74u AS=0.2516p AD=0.1406p
+ PS=2.16u PD=1.12u rfmode=0
M$83 \$283 \$55 \$284 \$7 sg13_lv_nmos L=0.13u W=0.74u AS=0.1406p AD=0.2516p
+ PS=1.12u PD=2.16u rfmode=0
M$84 \$7 \$284 \$285 \$7 sg13_lv_nmos L=0.13u W=0.74u AS=0.2516p AD=0.1406p
+ PS=2.16u PD=1.12u rfmode=0
M$85 \$285 \$267 \$286 \$7 sg13_lv_nmos L=0.13u W=0.74u AS=0.1406p AD=0.2516p
+ PS=1.12u PD=2.16u rfmode=0
M$86 \$7 \$286 \$162 \$7 sg13_lv_nmos L=0.13u W=0.74u AS=0.2516p AD=0.2516p
+ PS=2.16u PD=2.16u rfmode=0
M$87 \$7 \$160 \$287 \$7 sg13_lv_nmos L=0.13u W=0.74u AS=0.2516p AD=0.2516p
+ PS=2.16u PD=2.16u rfmode=0
M$88 \$7 \$287 \$288 \$7 sg13_lv_nmos L=0.13u W=0.74u AS=0.2516p AD=0.1406p
+ PS=2.16u PD=1.12u rfmode=0
M$89 \$288 \$49 \$289 \$7 sg13_lv_nmos L=0.13u W=0.74u AS=0.1406p AD=0.2516p
+ PS=1.12u PD=2.16u rfmode=0
M$90 \$7 \$289 \$268 \$7 sg13_lv_nmos L=0.13u W=0.74u AS=0.2516p AD=0.2516p
+ PS=2.16u PD=2.16u rfmode=0
M$91 \$7 \$162 \$290 \$7 sg13_lv_nmos L=0.13u W=0.74u AS=0.2516p AD=0.1406p
+ PS=2.16u PD=1.12u rfmode=0
M$92 \$290 \$268 \$269 \$7 sg13_lv_nmos L=0.13u W=0.74u AS=0.1406p AD=0.2516p
+ PS=1.12u PD=2.16u rfmode=0
M$93 \$349 \$349 \$7 \$7 sg13_lv_nmos L=0.56u W=0.42u AS=0.1428p AD=0.1428p
+ PS=1.52u PD=1.52u rfmode=0
M$94 \$7 \$505 \$348 \$7 sg13_lv_nmos L=0.13u W=0.74u AS=0.2516p AD=0.2516p
+ PS=2.16u PD=2.16u rfmode=0
M$95 \$7 \$159 \$357 \$7 sg13_lv_nmos L=0.13u W=0.74u AS=0.2516p AD=0.2516p
+ PS=2.16u PD=2.16u rfmode=0
M$96 \$7 \$357 \$358 \$7 sg13_lv_nmos L=0.13u W=0.74u AS=0.2516p AD=0.1406p
+ PS=2.16u PD=1.12u rfmode=0
M$97 \$358 \$37 \$359 \$7 sg13_lv_nmos L=0.13u W=0.74u AS=0.1406p AD=0.2516p
+ PS=1.12u PD=2.16u rfmode=0
M$98 \$7 \$359 \$360 \$7 sg13_lv_nmos L=0.13u W=0.74u AS=0.2516p AD=0.1406p
+ PS=2.16u PD=1.12u rfmode=0
M$99 \$360 \$348 \$361 \$7 sg13_lv_nmos L=0.13u W=0.74u AS=0.1406p AD=0.2516p
+ PS=1.12u PD=2.16u rfmode=0
M$100 \$7 \$361 \$352 \$7 sg13_lv_nmos L=0.13u W=0.74u AS=0.2516p AD=0.2516p
+ PS=2.16u PD=2.16u rfmode=0
M$101 \$7 \$265 \$362 \$7 sg13_lv_nmos L=0.13u W=0.74u AS=0.2516p AD=0.2516p
+ PS=2.16u PD=2.16u rfmode=0
M$102 \$7 \$362 \$363 \$7 sg13_lv_nmos L=0.13u W=0.74u AS=0.2516p AD=0.1406p
+ PS=2.16u PD=1.12u rfmode=0
M$103 \$363 \$352 \$211 \$7 sg13_lv_nmos L=0.13u W=0.74u AS=0.1406p AD=0.2516p
+ PS=1.12u PD=2.16u rfmode=0
M$104 \$292 \$291 \$293 \$7 sg13_lv_nmos L=0.13u W=0.74u AS=0.2516p AD=0.1406p
+ PS=2.16u PD=1.12u rfmode=0
M$105 \$293 \$269 \$294 \$7 sg13_lv_nmos L=0.13u W=0.74u AS=0.1406p AD=0.1406p
+ PS=1.12u PD=1.12u rfmode=0
M$106 \$294 \$191 \$7 \$7 sg13_lv_nmos L=0.13u W=0.74u AS=0.1406p AD=0.2516p
+ PS=1.12u PD=2.16u rfmode=0
M$107 \$7 \$292 \$295 \$7 sg13_lv_nmos L=0.13u W=0.74u AS=0.2516p AD=0.2516p
+ PS=2.16u PD=2.16u rfmode=0
M$108 \$7 \$420 \$429 \$7 sg13_lv_nmos L=0.56u W=0.42u AS=0.1428p AD=0.1428p
+ PS=1.52u PD=1.52u rfmode=0
M$109 \$420 \$420 \$7 \$7 sg13_lv_nmos L=0.56u W=0.42u AS=0.1428p AD=0.1428p
+ PS=1.52u PD=1.52u rfmode=0
M$110 \$7 \$376 \$413 \$7 sg13_lv_nmos L=0.56u W=0.42u AS=0.1428p AD=0.1428p
+ PS=1.52u PD=1.52u rfmode=0
M$111 \$7 \$14 \$389 \$7 sg13_lv_nmos L=0.15u W=0.5u AS=0.17p AD=0.17p PS=1.68u
+ PD=1.68u rfmode=0
M$112 \$7 \$349 \$376 \$7 sg13_lv_nmos L=0.56u W=0.42u AS=0.1428p AD=0.1428p
+ PS=1.52u PD=1.52u rfmode=0
M$113 \$7 \$413 \$417 \$7 sg13_lv_nmos L=0.13u W=0.74u AS=0.2516p AD=0.2516p
+ PS=2.16u PD=2.16u rfmode=0
M$114 \$7 \$417 \$266 \$7 sg13_lv_nmos L=0.13u W=0.74u AS=0.2516p AD=0.2516p
+ PS=2.16u PD=2.16u rfmode=0
M$115 \$7 \$266 \$377 \$7 sg13_lv_nmos L=0.13u W=0.74u AS=0.2516p AD=0.2516p
+ PS=2.16u PD=2.16u rfmode=0
M$116 \$7 \$377 \$378 \$7 sg13_lv_nmos L=0.13u W=0.74u AS=0.2516p AD=0.1406p
+ PS=2.16u PD=1.12u rfmode=0
M$117 \$378 \$55 \$291 \$7 sg13_lv_nmos L=0.13u W=0.74u AS=0.1406p AD=0.2516p
+ PS=1.12u PD=2.16u rfmode=0
M$118 \$7 \$14 \$430 \$7 sg13_lv_nmos L=0.15u W=0.5u AS=0.17p AD=0.17p PS=1.68u
+ PD=1.68u rfmode=0
M$119 \$7 \$429 \$448 \$7 sg13_lv_nmos L=0.56u W=0.42u AS=0.1428p AD=0.1428p
+ PS=1.52u PD=1.52u rfmode=0
M$120 \$451 \$451 \$7 \$7 sg13_lv_nmos L=0.56u W=0.42u AS=0.1428p AD=0.1428p
+ PS=1.52u PD=1.52u rfmode=0
M$121 \$7 \$451 \$458 \$7 sg13_lv_nmos L=0.56u W=0.42u AS=0.1428p AD=0.1428p
+ PS=1.52u PD=1.52u rfmode=0
M$122 \$7 \$14 \$463 \$7 sg13_lv_nmos L=0.15u W=0.5u AS=0.17p AD=0.17p PS=1.68u
+ PD=1.68u rfmode=0
M$123 \$7 \$458 \$476 \$7 sg13_lv_nmos L=0.56u W=0.42u AS=0.1428p AD=0.1428p
+ PS=1.52u PD=1.52u rfmode=0
M$124 \$482 \$482 \$7 \$7 sg13_lv_nmos L=0.56u W=0.42u AS=0.1428p AD=0.1428p
+ PS=1.52u PD=1.52u rfmode=0
M$125 \$7 \$482 \$487 \$7 sg13_lv_nmos L=0.56u W=0.42u AS=0.1428p AD=0.1428p
+ PS=1.52u PD=1.52u rfmode=0
M$126 \$7 \$14 \$488 \$7 sg13_lv_nmos L=0.15u W=0.5u AS=0.17p AD=0.17p PS=1.68u
+ PD=1.68u rfmode=0
M$127 \$7 \$487 \$505 \$7 sg13_lv_nmos L=0.56u W=0.42u AS=0.1428p AD=0.1428p
+ PS=1.52u PD=1.52u rfmode=0
M$128 \$3 \$1 \$4 \$20 sg13_lv_pmos L=0.3u W=10u AS=2.65p AD=2.65p PS=16.06u
+ PD=16.06u rfmode=0
M$130 \$3 \$12 \$13 \$20 sg13_lv_pmos L=0.3u W=10u AS=2.65p AD=2.65p PS=16.06u
+ PD=16.06u rfmode=0
M$132 \$20 \$19 \$19 \$20 sg13_lv_pmos L=0.15u W=10u AS=2.65p AD=2.65p
+ PS=16.06u PD=16.06u rfmode=0
M$134 \$20 \$19 \$3 \$20 sg13_lv_pmos L=0.15u W=10u AS=2.65p AD=2.65p PS=16.06u
+ PD=16.06u rfmode=0
M$136 \$20 \$19 \$37 \$20 sg13_lv_pmos L=0.15u W=5u AS=1.7p AD=1.7p PS=10.68u
+ PD=10.68u rfmode=0
M$137 \$20 \$81 \$38 \$20 sg13_lv_pmos L=0.13u W=1.12u AS=0.3808p AD=0.2128p
+ PS=2.92u PD=1.5u rfmode=0
M$138 \$38 \$35 \$39 \$20 sg13_lv_pmos L=0.13u W=1.12u AS=0.2128p AD=0.2128p
+ PS=1.5u PD=1.5u rfmode=0
M$139 \$39 \$29 \$40 \$20 sg13_lv_pmos L=0.13u W=1.12u AS=0.2128p AD=0.2128p
+ PS=1.5u PD=1.5u rfmode=0
M$140 \$40 \$80 \$20 \$20 sg13_lv_pmos L=0.13u W=1.12u AS=0.2128p AD=0.3808p
+ PS=1.5u PD=2.92u rfmode=0
M$141 \$20 \$39 \$80 \$20 sg13_lv_pmos L=0.13u W=1.12u AS=0.3808p AD=0.2128p
+ PS=2.92u PD=1.5u rfmode=0
M$142 \$80 \$29 \$41 \$20 sg13_lv_pmos L=0.13u W=1.12u AS=0.2128p AD=0.2128p
+ PS=1.5u PD=1.5u rfmode=0
M$143 \$41 \$35 \$42 \$20 sg13_lv_pmos L=0.13u W=1.12u AS=0.2128p AD=0.2128p
+ PS=1.5u PD=1.5u rfmode=0
M$144 \$42 \$81 \$20 \$20 sg13_lv_pmos L=0.13u W=1.12u AS=0.2128p AD=0.3808p
+ PS=1.5u PD=2.92u rfmode=0
M$145 \$20 \$41 \$81 \$20 sg13_lv_pmos L=0.13u W=1.12u AS=0.3808p AD=0.3808p
+ PS=2.92u PD=2.92u rfmode=0
M$146 \$20 \$81 \$43 \$20 sg13_lv_pmos L=0.13u W=1.12u AS=0.3808p AD=0.3808p
+ PS=2.92u PD=2.92u rfmode=0
M$147 \$20 \$35 \$29 \$20 sg13_lv_pmos L=0.13u W=1.12u AS=0.3808p AD=0.3808p
+ PS=2.92u PD=2.92u rfmode=0
M$148 \$20 \$83 \$44 \$20 sg13_lv_pmos L=0.13u W=1.12u AS=0.3808p AD=0.2128p
+ PS=2.92u PD=1.5u rfmode=0
M$149 \$44 \$43 \$45 \$20 sg13_lv_pmos L=0.13u W=1.12u AS=0.2128p AD=0.2128p
+ PS=1.5u PD=1.5u rfmode=0
M$150 \$45 \$30 \$46 \$20 sg13_lv_pmos L=0.13u W=1.12u AS=0.2128p AD=0.2128p
+ PS=1.5u PD=1.5u rfmode=0
M$151 \$46 \$82 \$20 \$20 sg13_lv_pmos L=0.13u W=1.12u AS=0.2128p AD=0.3808p
+ PS=1.5u PD=2.92u rfmode=0
M$152 \$20 \$45 \$82 \$20 sg13_lv_pmos L=0.13u W=1.12u AS=0.3808p AD=0.2128p
+ PS=2.92u PD=1.5u rfmode=0
M$153 \$82 \$30 \$47 \$20 sg13_lv_pmos L=0.13u W=1.12u AS=0.2128p AD=0.2128p
+ PS=1.5u PD=1.5u rfmode=0
M$154 \$47 \$43 \$48 \$20 sg13_lv_pmos L=0.13u W=1.12u AS=0.2128p AD=0.2128p
+ PS=1.5u PD=1.5u rfmode=0
M$155 \$48 \$83 \$20 \$20 sg13_lv_pmos L=0.13u W=1.12u AS=0.2128p AD=0.3808p
+ PS=1.5u PD=2.92u rfmode=0
M$156 \$20 \$47 \$83 \$20 sg13_lv_pmos L=0.13u W=1.12u AS=0.3808p AD=0.3808p
+ PS=2.92u PD=2.92u rfmode=0
M$157 \$20 \$83 \$49 \$20 sg13_lv_pmos L=0.13u W=1.12u AS=0.3808p AD=0.3808p
+ PS=2.92u PD=2.92u rfmode=0
M$158 \$20 \$43 \$30 \$20 sg13_lv_pmos L=0.13u W=1.12u AS=0.3808p AD=0.3808p
+ PS=2.92u PD=2.92u rfmode=0
M$159 \$20 \$143 \$159 \$20 sg13_lv_pmos L=0.15u W=5u AS=1.7p AD=1.7p PS=10.68u
+ PD=10.68u rfmode=0
M$160 \$20 \$143 \$97 \$20 sg13_lv_pmos L=0.15u W=10u AS=2.65p AD=2.65p
+ PS=16.06u PD=16.06u rfmode=0
M$162 \$20 \$143 \$143 \$20 sg13_lv_pmos L=0.15u W=10u AS=2.65p AD=2.65p
+ PS=16.06u PD=16.06u rfmode=0
M$164 \$97 \$12 \$101 \$20 sg13_lv_pmos L=0.3u W=10u AS=2.65p AD=2.65p
+ PS=16.06u PD=16.06u rfmode=0
M$166 \$97 \$36 \$98 \$20 sg13_lv_pmos L=0.3u W=10u AS=2.65p AD=2.65p PS=16.06u
+ PD=16.06u rfmode=0
M$168 \$210 \$151 \$212 \$20 sg13_lv_pmos L=0.3u W=10u AS=2.65p AD=2.65p
+ PS=16.06u PD=16.06u rfmode=0
M$170 \$20 \$476 \$154 \$20 sg13_lv_pmos L=0.13u W=1.12u AS=0.3808p AD=0.3808p
+ PS=2.92u PD=2.92u rfmode=0
M$171 \$20 \$413 \$165 \$20 sg13_lv_pmos L=0.13u W=1.12u AS=0.3808p AD=0.3808p
+ PS=2.92u PD=2.92u rfmode=0
M$172 \$20 \$165 \$167 \$20 sg13_lv_pmos L=0.13u W=1.12u AS=0.3808p AD=0.2128p
+ PS=2.92u PD=1.5u rfmode=0
M$173 \$167 \$159 \$20 \$20 sg13_lv_pmos L=0.13u W=1.12u AS=0.2128p AD=0.3808p
+ PS=1.5u PD=2.92u rfmode=0
M$174 \$20 \$167 \$160 \$20 sg13_lv_pmos L=0.13u W=1.12u AS=0.3808p AD=0.2128p
+ PS=2.92u PD=1.5u rfmode=0
M$175 \$160 \$154 \$20 \$20 sg13_lv_pmos L=0.13u W=1.12u AS=0.2128p AD=0.3808p
+ PS=1.5u PD=2.92u rfmode=0
M$176 \$20 \$85 \$50 \$20 sg13_lv_pmos L=0.13u W=1.12u AS=0.3808p AD=0.2128p
+ PS=2.92u PD=1.5u rfmode=0
M$177 \$50 \$49 \$51 \$20 sg13_lv_pmos L=0.13u W=1.12u AS=0.2128p AD=0.2128p
+ PS=1.5u PD=1.5u rfmode=0
M$178 \$51 \$31 \$52 \$20 sg13_lv_pmos L=0.13u W=1.12u AS=0.2128p AD=0.2128p
+ PS=1.5u PD=1.5u rfmode=0
M$179 \$52 \$84 \$20 \$20 sg13_lv_pmos L=0.13u W=1.12u AS=0.2128p AD=0.3808p
+ PS=1.5u PD=2.92u rfmode=0
M$180 \$20 \$51 \$84 \$20 sg13_lv_pmos L=0.13u W=1.12u AS=0.3808p AD=0.2128p
+ PS=2.92u PD=1.5u rfmode=0
M$181 \$84 \$31 \$53 \$20 sg13_lv_pmos L=0.13u W=1.12u AS=0.2128p AD=0.2128p
+ PS=1.5u PD=1.5u rfmode=0
M$182 \$53 \$49 \$54 \$20 sg13_lv_pmos L=0.13u W=1.12u AS=0.2128p AD=0.2128p
+ PS=1.5u PD=1.5u rfmode=0
M$183 \$54 \$85 \$20 \$20 sg13_lv_pmos L=0.13u W=1.12u AS=0.2128p AD=0.3808p
+ PS=1.5u PD=2.92u rfmode=0
M$184 \$20 \$53 \$85 \$20 sg13_lv_pmos L=0.13u W=1.12u AS=0.3808p AD=0.3808p
+ PS=2.92u PD=2.92u rfmode=0
M$185 \$20 \$85 \$55 \$20 sg13_lv_pmos L=0.13u W=1.12u AS=0.3808p AD=0.3808p
+ PS=2.92u PD=2.92u rfmode=0
M$186 \$20 \$49 \$31 \$20 sg13_lv_pmos L=0.13u W=1.12u AS=0.3808p AD=0.3808p
+ PS=2.92u PD=2.92u rfmode=0
M$187 \$20 \$49 \$176 \$20 sg13_lv_pmos L=0.13u W=1.12u AS=0.3808p AD=0.2128p
+ PS=2.92u PD=1.5u rfmode=0
M$188 \$176 \$160 \$20 \$20 sg13_lv_pmos L=0.13u W=1.12u AS=0.2128p AD=0.3808p
+ PS=1.5u PD=2.92u rfmode=0
M$189 \$20 \$176 \$178 \$20 sg13_lv_pmos L=0.13u W=1.12u AS=0.3808p AD=0.2128p
+ PS=2.92u PD=1.5u rfmode=0
M$190 \$178 \$160 \$20 \$20 sg13_lv_pmos L=0.13u W=1.12u AS=0.2128p AD=0.3808p
+ PS=1.5u PD=2.92u rfmode=0
M$191 \$20 \$176 \$180 \$20 sg13_lv_pmos L=0.13u W=1.12u AS=0.3808p AD=0.2128p
+ PS=2.92u PD=1.5u rfmode=0
M$192 \$180 \$49 \$20 \$20 sg13_lv_pmos L=0.13u W=1.12u AS=0.2128p AD=0.3808p
+ PS=1.5u PD=2.92u rfmode=0
M$193 \$20 \$180 \$182 \$20 sg13_lv_pmos L=0.13u W=1.12u AS=0.3808p AD=0.2128p
+ PS=2.92u PD=1.5u rfmode=0
M$194 \$182 \$178 \$20 \$20 sg13_lv_pmos L=0.13u W=1.12u AS=0.2128p AD=0.3808p
+ PS=1.5u PD=2.92u rfmode=0
M$195 \$20 \$182 \$183 \$20 sg13_lv_pmos L=0.13u W=1.12u AS=0.3808p AD=0.3808p
+ PS=2.92u PD=2.92u rfmode=0
M$196 \$20 \$211 \$184 \$20 sg13_lv_pmos L=0.13u W=1.12u AS=0.3808p AD=0.3808p
+ PS=2.92u PD=2.92u rfmode=0
M$197 \$20 \$184 \$186 \$20 sg13_lv_pmos L=0.13u W=1.12u AS=0.3808p AD=0.2128p
+ PS=2.92u PD=1.5u rfmode=0
M$198 \$186 \$43 \$20 \$20 sg13_lv_pmos L=0.13u W=1.12u AS=0.2128p AD=0.3808p
+ PS=1.5u PD=2.92u rfmode=0
M$199 \$20 \$186 \$161 \$20 sg13_lv_pmos L=0.13u W=1.12u AS=0.3808p AD=0.3808p
+ PS=2.92u PD=2.92u rfmode=0
M$200 \$20 \$183 \$188 \$20 sg13_lv_pmos L=0.13u W=1.12u AS=0.3808p AD=0.2128p
+ PS=2.92u PD=1.5u rfmode=0
M$201 \$188 \$161 \$20 \$20 sg13_lv_pmos L=0.13u W=1.12u AS=0.2128p AD=0.3808p
+ PS=1.5u PD=2.92u rfmode=0
M$202 \$20 \$188 \$189 \$20 sg13_lv_pmos L=0.13u W=1.12u AS=0.3808p AD=0.3808p
+ PS=2.92u PD=2.92u rfmode=0
M$203 \$20 \$189 \$191 \$20 sg13_lv_pmos L=0.13u W=1.12u AS=0.3808p AD=0.2128p
+ PS=2.92u PD=1.5u rfmode=0
M$204 \$191 \$162 \$20 \$20 sg13_lv_pmos L=0.13u W=1.12u AS=0.2128p AD=0.3808p
+ PS=1.5u PD=2.92u rfmode=0
M$205 \$20 \$251 \$210 \$20 sg13_lv_pmos L=0.15u W=10u AS=2.65p AD=2.65p
+ PS=16.06u PD=16.06u rfmode=0
M$207 \$20 \$251 \$251 \$20 sg13_lv_pmos L=0.15u W=10u AS=2.65p AD=2.65p
+ PS=16.06u PD=16.06u rfmode=0
M$209 \$210 \$12 \$244 \$20 sg13_lv_pmos L=0.3u W=10u AS=2.65p AD=2.65p
+ PS=16.06u PD=16.06u rfmode=0
M$211 \$20 \$413 \$259 \$20 sg13_lv_pmos L=0.13u W=1.12u AS=0.3808p AD=0.3808p
+ PS=2.92u PD=2.92u rfmode=0
M$212 \$20 \$259 \$252 \$20 sg13_lv_pmos L=0.13u W=1.12u AS=0.3808p AD=0.2128p
+ PS=2.92u PD=1.5u rfmode=0
M$213 \$252 \$325 \$20 \$20 sg13_lv_pmos L=0.13u W=1.12u AS=0.2128p AD=0.3808p
+ PS=1.5u PD=2.92u rfmode=0
M$214 \$20 \$476 \$261 \$20 sg13_lv_pmos L=0.13u W=1.12u AS=0.3808p AD=0.3808p
+ PS=2.92u PD=2.92u rfmode=0
M$215 \$20 \$261 \$263 \$20 sg13_lv_pmos L=0.13u W=1.12u AS=0.3808p AD=0.2128p
+ PS=2.92u PD=1.5u rfmode=0
M$216 \$263 \$448 \$20 \$20 sg13_lv_pmos L=0.13u W=1.12u AS=0.2128p AD=0.3808p
+ PS=1.5u PD=2.92u rfmode=0
M$217 \$20 \$263 \$265 \$20 sg13_lv_pmos L=0.13u W=1.12u AS=0.3808p AD=0.2128p
+ PS=2.92u PD=1.5u rfmode=0
M$218 \$265 \$252 \$20 \$20 sg13_lv_pmos L=0.13u W=1.12u AS=0.2128p AD=0.3808p
+ PS=1.5u PD=2.92u rfmode=0
M$219 \$20 \$55 \$281 \$20 sg13_lv_pmos L=0.13u W=1.12u AS=0.3808p AD=0.2128p
+ PS=2.92u PD=1.5u rfmode=0
M$220 \$281 \$266 \$20 \$20 sg13_lv_pmos L=0.13u W=1.12u AS=0.2128p AD=0.3808p
+ PS=1.5u PD=2.92u rfmode=0
M$221 \$20 \$281 \$267 \$20 sg13_lv_pmos L=0.13u W=1.12u AS=0.3808p AD=0.2128p
+ PS=2.92u PD=1.5u rfmode=0
M$222 \$267 \$266 \$20 \$20 sg13_lv_pmos L=0.13u W=1.12u AS=0.2128p AD=0.3808p
+ PS=1.5u PD=2.92u rfmode=0
M$223 \$20 \$281 \$284 \$20 sg13_lv_pmos L=0.13u W=1.12u AS=0.3808p AD=0.2128p
+ PS=2.92u PD=1.5u rfmode=0
M$224 \$284 \$55 \$20 \$20 sg13_lv_pmos L=0.13u W=1.12u AS=0.2128p AD=0.3808p
+ PS=1.5u PD=2.92u rfmode=0
M$225 \$20 \$284 \$286 \$20 sg13_lv_pmos L=0.13u W=1.12u AS=0.3808p AD=0.2128p
+ PS=2.92u PD=1.5u rfmode=0
M$226 \$286 \$267 \$20 \$20 sg13_lv_pmos L=0.13u W=1.12u AS=0.2128p AD=0.3808p
+ PS=1.5u PD=2.92u rfmode=0
M$227 \$20 \$286 \$162 \$20 sg13_lv_pmos L=0.13u W=1.12u AS=0.3808p AD=0.3808p
+ PS=2.92u PD=2.92u rfmode=0
M$228 \$20 \$160 \$287 \$20 sg13_lv_pmos L=0.13u W=1.12u AS=0.3808p AD=0.3808p
+ PS=2.92u PD=2.92u rfmode=0
M$229 \$20 \$287 \$289 \$20 sg13_lv_pmos L=0.13u W=1.12u AS=0.3808p AD=0.2128p
+ PS=2.92u PD=1.5u rfmode=0
M$230 \$289 \$49 \$20 \$20 sg13_lv_pmos L=0.13u W=1.12u AS=0.2128p AD=0.3808p
+ PS=1.5u PD=2.92u rfmode=0
M$231 \$20 \$289 \$268 \$20 sg13_lv_pmos L=0.13u W=1.12u AS=0.3808p AD=0.3808p
+ PS=2.92u PD=2.92u rfmode=0
M$232 \$20 \$162 \$269 \$20 sg13_lv_pmos L=0.13u W=1.12u AS=0.3808p AD=0.2128p
+ PS=2.92u PD=1.5u rfmode=0
M$233 \$269 \$268 \$20 \$20 sg13_lv_pmos L=0.13u W=1.12u AS=0.2128p AD=0.3808p
+ PS=1.5u PD=2.92u rfmode=0
M$234 \$20 \$251 \$325 \$20 sg13_lv_pmos L=0.15u W=5u AS=1.7p AD=1.7p PS=10.68u
+ PD=10.68u rfmode=0
M$235 \$347 \$250 \$349 \$20 sg13_lv_pmos L=0.3u W=10u AS=2.65p AD=2.65p
+ PS=16.06u PD=16.06u rfmode=0
M$237 \$347 \$12 \$376 \$20 sg13_lv_pmos L=0.3u W=10u AS=2.65p AD=2.65p
+ PS=16.06u PD=16.06u rfmode=0
M$239 \$20 \$505 \$348 \$20 sg13_lv_pmos L=0.13u W=1.12u AS=0.3808p AD=0.3808p
+ PS=2.92u PD=2.92u rfmode=0
M$240 \$20 \$159 \$357 \$20 sg13_lv_pmos L=0.13u W=1.12u AS=0.3808p AD=0.3808p
+ PS=2.92u PD=2.92u rfmode=0
M$241 \$20 \$357 \$359 \$20 sg13_lv_pmos L=0.13u W=1.12u AS=0.3808p AD=0.2128p
+ PS=2.92u PD=1.5u rfmode=0
M$242 \$359 \$37 \$20 \$20 sg13_lv_pmos L=0.13u W=1.12u AS=0.2128p AD=0.3808p
+ PS=1.5u PD=2.92u rfmode=0
M$243 \$20 \$359 \$361 \$20 sg13_lv_pmos L=0.13u W=1.12u AS=0.3808p AD=0.2128p
+ PS=2.92u PD=1.5u rfmode=0
M$244 \$361 \$348 \$20 \$20 sg13_lv_pmos L=0.13u W=1.12u AS=0.2128p AD=0.3808p
+ PS=1.5u PD=2.92u rfmode=0
M$245 \$20 \$361 \$352 \$20 sg13_lv_pmos L=0.13u W=1.12u AS=0.3808p AD=0.3808p
+ PS=2.92u PD=2.92u rfmode=0
M$246 \$20 \$265 \$362 \$20 sg13_lv_pmos L=0.13u W=1.12u AS=0.3808p AD=0.3808p
+ PS=2.92u PD=2.92u rfmode=0
M$247 \$20 \$362 \$211 \$20 sg13_lv_pmos L=0.13u W=1.12u AS=0.3808p AD=0.2128p
+ PS=2.92u PD=1.5u rfmode=0
M$248 \$211 \$352 \$20 \$20 sg13_lv_pmos L=0.13u W=1.12u AS=0.2128p AD=0.3808p
+ PS=1.5u PD=2.92u rfmode=0
M$249 \$20 \$266 \$377 \$20 sg13_lv_pmos L=0.13u W=1.12u AS=0.3808p AD=0.3808p
+ PS=2.92u PD=2.92u rfmode=0
M$250 \$20 \$377 \$291 \$20 sg13_lv_pmos L=0.13u W=1.12u AS=0.3808p AD=0.2128p
+ PS=2.92u PD=1.5u rfmode=0
M$251 \$291 \$55 \$20 \$20 sg13_lv_pmos L=0.13u W=1.12u AS=0.2128p AD=0.3808p
+ PS=1.5u PD=2.92u rfmode=0
M$252 \$20 \$291 \$292 \$20 sg13_lv_pmos L=0.13u W=1.12u AS=0.3808p AD=0.2128p
+ PS=2.92u PD=1.5u rfmode=0
M$253 \$292 \$269 \$20 \$20 sg13_lv_pmos L=0.13u W=1.12u AS=0.2128p AD=0.2128p
+ PS=1.5u PD=1.5u rfmode=0
M$254 \$20 \$191 \$292 \$20 sg13_lv_pmos L=0.13u W=1.12u AS=0.2128p AD=0.3808p
+ PS=1.5u PD=2.92u rfmode=0
M$255 \$20 \$292 \$295 \$20 sg13_lv_pmos L=0.13u W=1.12u AS=0.3808p AD=0.3808p
+ PS=2.92u PD=2.92u rfmode=0
M$256 \$20 \$389 \$413 \$20 sg13_lv_pmos L=0.15u W=5u AS=1.7p AD=1.7p PS=10.68u
+ PD=10.68u rfmode=0
M$257 \$20 \$389 \$347 \$20 sg13_lv_pmos L=0.15u W=10u AS=2.65p AD=2.65p
+ PS=16.06u PD=16.06u rfmode=0
M$259 \$20 \$389 \$389 \$20 sg13_lv_pmos L=0.15u W=10u AS=2.65p AD=2.65p
+ PS=16.06u PD=16.06u rfmode=0
M$261 \$20 \$413 \$417 \$20 sg13_lv_pmos L=0.13u W=1.12u AS=0.3808p AD=0.3808p
+ PS=2.92u PD=2.92u rfmode=0
M$262 \$20 \$417 \$266 \$20 sg13_lv_pmos L=0.13u W=1.12u AS=0.3808p AD=0.3808p
+ PS=2.92u PD=2.92u rfmode=0
M$263 \$416 \$388 \$420 \$20 sg13_lv_pmos L=0.3u W=10u AS=2.65p AD=2.65p
+ PS=16.06u PD=16.06u rfmode=0
M$265 \$416 \$12 \$429 \$20 sg13_lv_pmos L=0.3u W=10u AS=2.65p AD=2.65p
+ PS=16.06u PD=16.06u rfmode=0
M$267 \$20 \$430 \$430 \$20 sg13_lv_pmos L=0.15u W=10u AS=2.65p AD=2.65p
+ PS=16.06u PD=16.06u rfmode=0
M$269 \$20 \$430 \$416 \$20 sg13_lv_pmos L=0.15u W=10u AS=2.65p AD=2.65p
+ PS=16.06u PD=16.06u rfmode=0
M$271 \$20 \$430 \$448 \$20 sg13_lv_pmos L=0.15u W=5u AS=1.7p AD=1.7p PS=10.68u
+ PD=10.68u rfmode=0
M$272 \$447 \$436 \$451 \$20 sg13_lv_pmos L=0.3u W=10u AS=2.65p AD=2.65p
+ PS=16.06u PD=16.06u rfmode=0
M$274 \$447 \$12 \$458 \$20 sg13_lv_pmos L=0.3u W=10u AS=2.65p AD=2.65p
+ PS=16.06u PD=16.06u rfmode=0
M$276 \$20 \$463 \$463 \$20 sg13_lv_pmos L=0.15u W=10u AS=2.65p AD=2.65p
+ PS=16.06u PD=16.06u rfmode=0
M$278 \$20 \$463 \$447 \$20 sg13_lv_pmos L=0.15u W=10u AS=2.65p AD=2.65p
+ PS=16.06u PD=16.06u rfmode=0
M$280 \$20 \$463 \$476 \$20 sg13_lv_pmos L=0.15u W=5u AS=1.7p AD=1.7p PS=10.68u
+ PD=10.68u rfmode=0
M$281 \$479 \$467 \$482 \$20 sg13_lv_pmos L=0.3u W=10u AS=2.65p AD=2.65p
+ PS=16.06u PD=16.06u rfmode=0
M$283 \$479 \$12 \$487 \$20 sg13_lv_pmos L=0.3u W=10u AS=2.65p AD=2.65p
+ PS=16.06u PD=16.06u rfmode=0
M$285 \$20 \$488 \$488 \$20 sg13_lv_pmos L=0.15u W=10u AS=2.65p AD=2.65p
+ PS=16.06u PD=16.06u rfmode=0
M$287 \$20 \$488 \$479 \$20 sg13_lv_pmos L=0.15u W=10u AS=2.65p AD=2.65p
+ PS=16.06u PD=16.06u rfmode=0
M$289 \$20 \$488 \$505 \$20 sg13_lv_pmos L=0.15u W=5u AS=1.7p AD=1.7p PS=10.68u
+ PD=10.68u rfmode=0
R$290 \$7 \$1 \$7 rppd w=0.5u l=4u ps=0u b=0 m=1
R$291 \$1 \$36 \$7 rppd w=0.5u l=2u ps=0u b=0 m=1
R$292 \$36 \$151 \$7 rppd w=0.5u l=2u ps=0u b=0 m=1
R$293 \$151 \$250 \$7 rppd w=0.5u l=2u ps=0u b=0 m=1
R$294 \$250 \$388 \$7 rppd w=0.5u l=2u ps=0u b=0 m=1
R$295 \$388 \$436 \$7 rppd w=0.5u l=2u ps=0u b=0 m=1
R$296 \$436 \$467 \$7 rppd w=0.5u l=2u ps=0u b=0 m=1
R$297 \$467 \$20 \$7 rppd w=0.5u l=4u ps=0u b=0 m=1
.ENDS PWMADCSYM
